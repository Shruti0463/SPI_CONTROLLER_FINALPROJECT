* CDL Netlist generated by OpenROAD

*.BUSDELIMITER [

.SUBCKT spi_master busy clk cs_n done miso mosi rst_n rx_data[0]
+ rx_data[1] rx_data[2] rx_data[3] rx_data[4] rx_data[5] rx_data[6]
+ rx_data[7] sclk start tx_data[0] tx_data[1] tx_data[2] tx_data[3]
+ tx_data[4] tx_data[5] tx_data[6] tx_data[7] VDD VSS
Xinput7 tx_data[3] VSS VSS VDD VDD net7 sky130_fd_sc_hd__clkdlybuf4s50_1
Xinput6 tx_data[2] VSS VSS VDD VDD net6 sky130_fd_sc_hd__clkdlybuf4s50_1
X_139_ div_cnt\[5\] div_cnt\[2\] div_cnt\[3\] _000_ VSS VSS
+ VDD VDD _124_ sky130_fd_sc_hd__or4b_4
Xinput5 tx_data[1] VSS VSS VDD VDD net5 sky130_fd_sc_hd__clkdlybuf4s50_1
X_141_ div_cnt\[6\] div_cnt\[7\] div_cnt\[4\] VSS VSS VDD
+ VDD _126_ sky130_fd_sc_hd__or3_2
X_142_ net24 _124_ _126_ VSS VSS VDD VDD _127_ sky130_fd_sc_hd__nor3_2
X_143_ net24 VSS VSS VDD VDD _128_ sky130_fd_sc_hd__inv_1
Xinput4 tx_data[0] VSS VSS VDD VDD net4 sky130_fd_sc_hd__clkdlybuf4s50_1
X_145_ state\[2\] net3 state\[0\] VSS VSS VDD VDD _130_ sky130_fd_sc_hd__mux2_2
X_146_ div_cnt\[5\] div_cnt\[2\] div_cnt\[3\] _000_ VSS VSS
+ VDD VDD _131_ sky130_fd_sc_hd__nor4b_1
X_147_ div_cnt\[6\] div_cnt\[7\] div_cnt\[4\] VSS VSS VDD
+ VDD _132_ sky130_fd_sc_hd__nor3_1
X_148_ _128_ _130_ _131_ _132_ VSS VSS VDD VDD _133_ sky130_fd_sc_hd__nand4_1
X_149_ shreg\[6\] _127_ _133_ shreg\[5\] VSS VSS VDD VDD _134_
+ sky130_fd_sc_hd__o22ai_1
Xinput3 start VSS VSS VDD VDD net3 sky130_fd_sc_hd__clkdlybuf4s50_1
X_151_ state\[2\] VSS VSS VDD VDD _042_ sky130_fd_sc_hd__inv_1
X_152_ _042_ _130_ VSS VSS VDD VDD _043_ sky130_fd_sc_hd__nand2_1
X_153_ shreg\[6\] _130_ _043_ net10 VSS VSS VDD VDD _044_
+ sky130_fd_sc_hd__o22ai_1
X_154_ state\[2\] _134_ _044_ VSS VSS VDD VDD _009_ sky130_fd_sc_hd__a21oi_1
X_155_ shreg\[5\] _127_ _133_ shreg\[4\] VSS VSS VDD VDD _045_
+ sky130_fd_sc_hd__o22ai_1
X_156_ shreg\[5\] _130_ _043_ net9 VSS VSS VDD VDD _046_ sky130_fd_sc_hd__o22ai_1
X_157_ state\[2\] _045_ _046_ VSS VSS VDD VDD _010_ sky130_fd_sc_hd__a21oi_1
Xinput2 rst_n VSS VSS VDD VDD net2 sky130_fd_sc_hd__clkdlybuf4s50_1
X_159_ shreg\[4\] state\[2\] VSS VSS VDD VDD _048_ sky130_fd_sc_hd__nand2_1
X_160_ state\[2\] net3 state\[0\] VSS VSS VDD VDD _049_ sky130_fd_sc_hd__mux2i_1
Xinput1 miso VSS VSS VDD VDD net1 sky130_fd_sc_hd__clkdlybuf4s50_1
X_162_ _042_ net8 _130_ VSS VSS VDD VDD _051_ sky130_fd_sc_hd__and3_1
X_163_ shreg\[4\] _049_ _051_ VSS VSS VDD VDD _052_ sky130_fd_sc_hd__a21oi_1
X_164_ state\[2\] shreg\[3\] _130_ _127_ VSS VSS VDD VDD _053_
+ sky130_fd_sc_hd__nand4_1
X_165_ _127_ _048_ _052_ _053_ VSS VSS VDD VDD _011_ sky130_fd_sc_hd__o211ai_1
X_166_ shreg\[3\] _127_ _133_ shreg\[2\] VSS VSS VDD VDD _054_
+ sky130_fd_sc_hd__o22ai_1
X_167_ shreg\[3\] _130_ _043_ net7 VSS VSS VDD VDD _055_ sky130_fd_sc_hd__o22ai_1
X_168_ state\[2\] _054_ _055_ VSS VSS VDD VDD _012_ sky130_fd_sc_hd__a21oi_1
X_169_ shreg\[2\] _127_ _133_ shreg\[1\] VSS VSS VDD VDD _056_
+ sky130_fd_sc_hd__o22ai_1
X_170_ shreg\[2\] _130_ _043_ net6 VSS VSS VDD VDD _057_ sky130_fd_sc_hd__o22ai_1
X_171_ state\[2\] _056_ _057_ VSS VSS VDD VDD _013_ sky130_fd_sc_hd__a21oi_1
X_172_ shreg\[1\] _127_ _133_ shreg\[0\] VSS VSS VDD VDD _058_
+ sky130_fd_sc_hd__o22ai_1
X_173_ shreg\[1\] _130_ _043_ net5 VSS VSS VDD VDD _059_ sky130_fd_sc_hd__o22ai_1
X_174_ state\[2\] _058_ _059_ VSS VSS VDD VDD _014_ sky130_fd_sc_hd__a21oi_1
X_175_ shreg\[0\] _127_ _133_ net1 VSS VSS VDD VDD _060_ sky130_fd_sc_hd__o22ai_1
X_176_ shreg\[0\] _130_ _043_ net4 VSS VSS VDD VDD _061_ sky130_fd_sc_hd__o22ai_1
X_177_ state\[2\] _060_ _061_ VSS VSS VDD VDD _015_ sky130_fd_sc_hd__a21oi_1
X_178_ bit_cnt\[2\] _049_ VSS VSS VDD VDD _062_ sky130_fd_sc_hd__nand2_1
X_179_ div_cnt\[6\] div_cnt\[7\] VSS VSS VDD VDD _063_ sky130_fd_sc_hd__nor2_1
X_180_ div_cnt\[4\] _128_ _124_ _063_ VSS VSS VDD VDD _064_
+ sky130_fd_sc_hd__nor4b_4
X_181_ state\[2\] bit_cnt\[2\] VSS VSS VDD VDD _065_ sky130_fd_sc_hd__nand2_1
X_182_ _005_ _064_ _065_ VSS VSS VDD VDD _066_ sky130_fd_sc_hd__a21o_1
X_183_ _042_ bit_cnt\[2\] _049_ VSS VSS VDD VDD _067_ sky130_fd_sc_hd__nor3_1
X_184_ _005_ _064_ _067_ VSS VSS VDD VDD _068_ sky130_fd_sc_hd__nand3_1
X_185_ _062_ _066_ _068_ VSS VSS VDD VDD _016_ sky130_fd_sc_hd__nand3_1
X_186_ bit_cnt\[1\] _049_ VSS VSS VDD VDD _069_ sky130_fd_sc_hd__nand2_1
X_187_ state\[2\] _004_ _130_ _064_ VSS VSS VDD VDD _070_
+ sky130_fd_sc_hd__nand4_1
X_188_ div_cnt\[4\] net24 _131_ _063_ VSS VSS VDD VDD _071_
+ sky130_fd_sc_hd__nand4b_1
X_189_ state\[2\] bit_cnt\[1\] _071_ VSS VSS VDD VDD _072_
+ sky130_fd_sc_hd__nand3_1
X_190_ _069_ _070_ _072_ VSS VSS VDD VDD _017_ sky130_fd_sc_hd__nand3_1
X_191_ net3 state\[0\] VSS VSS VDD VDD _073_ sky130_fd_sc_hd__nor2b_1
X_192_ state\[2\] bit_cnt\[0\] VSS VSS VDD VDD _074_ sky130_fd_sc_hd__nand2_1
X_193_ _064_ _074_ bit_cnt\[0\] _049_ VSS VSS VDD VDD _075_
+ sky130_fd_sc_hd__a2bb2oi_1
X_194_ _042_ bit_cnt\[0\] _073_ _071_ _075_ VSS VSS VDD VDD
+ _018_ sky130_fd_sc_hd__o41ai_1
X_195_ _131_ _132_ _042_ _073_ VSS VSS VDD VDD _076_ sky130_fd_sc_hd__a211oi_1
X_196_ div_cnt\[4\] div_cnt\[5\] div_cnt\[2\] div_cnt\[3\]
+ VSS VSS VDD VDD _077_ sky130_fd_sc_hd__and4_2
X_197_ _002_ _077_ VSS VSS VDD VDD _078_ sky130_fd_sc_hd__nand2_1
X_198_ _076_ _078_ VSS VSS VDD VDD _079_ sky130_fd_sc_hd__nand2_1
X_199_ _002_ _076_ _077_ div_cnt\[6\] VSS VSS VDD VDD _080_
+ sky130_fd_sc_hd__a31oi_1
X_200_ div_cnt\[6\] _130_ _079_ _080_ VSS VSS VDD VDD _019_
+ sky130_fd_sc_hd__a31oi_1
X_201_ _131_ _132_ VSS VSS VDD VDD _081_ sky130_fd_sc_hd__nand2_1
X_202_ div_cnt\[0\] div_cnt\[1\] _077_ VSS VSS VDD VDD _082_
+ sky130_fd_sc_hd__nand3_1
X_203_ state\[2\] _081_ _082_ VSS VSS VDD VDD _083_ sky130_fd_sc_hd__nand3_1
X_204_ div_cnt\[2\] div_cnt\[0\] div_cnt\[1\] VSS VSS VDD
+ VDD _084_ sky130_fd_sc_hd__and3_2
X_205_ div_cnt\[4\] div_cnt\[3\] _076_ _084_ div_cnt\[5\]
+ VSS VSS VDD VDD _085_ sky130_fd_sc_hd__a41oi_1
X_206_ _130_ _083_ _085_ VSS VSS VDD VDD _020_ sky130_fd_sc_hd__a21oi_1
X_207_ div_cnt\[2\] div_cnt\[3\] _002_ VSS VSS VDD VDD _086_
+ sky130_fd_sc_hd__nand3_1
X_208_ div_cnt\[4\] _073_ _086_ VSS VSS VDD VDD _087_ sky130_fd_sc_hd__nor3_1
X_209_ div_cnt\[4\] _086_ _087_ VSS VSS VDD VDD _088_ sky130_fd_sc_hd__a21oi_1
X_210_ div_cnt\[4\] _049_ VSS VSS VDD VDD _089_ sky130_fd_sc_hd__nand2_1
X_211_ _042_ _088_ _089_ VSS VSS VDD VDD _021_ sky130_fd_sc_hd__o21ai_0
X_212_ div_cnt\[3\] _073_ VSS VSS VDD VDD _090_ sky130_fd_sc_hd__nor2_1
X_213_ div_cnt\[3\] _090_ _084_ VSS VSS VDD VDD _091_ sky130_fd_sc_hd__mux2i_1
X_214_ div_cnt\[3\] _049_ VSS VSS VDD VDD _092_ sky130_fd_sc_hd__nand2_1
X_215_ _042_ _091_ _092_ VSS VSS VDD VDD _022_ sky130_fd_sc_hd__o21ai_0
X_216_ _002_ VSS VSS VDD VDD _093_ sky130_fd_sc_hd__inv_1
X_217_ div_cnt\[2\] _093_ _073_ VSS VSS VDD VDD _094_ sky130_fd_sc_hd__nor3_1
X_218_ div_cnt\[2\] _093_ _081_ _094_ VSS VSS VDD VDD _095_
+ sky130_fd_sc_hd__a22o_2
X_219_ div_cnt\[2\] _049_ _095_ state\[2\] VSS VSS VDD VDD
+ _023_ sky130_fd_sc_hd__a22o_2
X_220_ div_cnt\[1\] _049_ _076_ _001_ VSS VSS VDD VDD _024_
+ sky130_fd_sc_hd__a22o_1
X_221_ _076_ _049_ div_cnt\[0\] VSS VSS VDD VDD _025_ sky130_fd_sc_hd__mux2_2
X_222_ _128_ _124_ _126_ VSS VSS VDD VDD _096_ sky130_fd_sc_hd__nor3_4
X_223_ bit_cnt\[3\] bit_cnt\[2\] _003_ VSS VSS VDD VDD _097_
+ sky130_fd_sc_hd__and3b_1
X_224_ state\[2\] _096_ _097_ VSS VSS VDD VDD _098_ sky130_fd_sc_hd__nand3_4
X_225_ shreg\[6\] net22 _098_ VSS VSS VDD VDD _026_ sky130_fd_sc_hd__mux2_4
X_226_ shreg\[5\] net21 _098_ VSS VSS VDD VDD _027_ sky130_fd_sc_hd__mux2_4
X_227_ shreg\[4\] net20 _098_ VSS VSS VDD VDD _028_ sky130_fd_sc_hd__mux2_2
X_228_ shreg\[3\] net19 _098_ VSS VSS VDD VDD _029_ sky130_fd_sc_hd__mux2_2
X_229_ shreg\[2\] net18 _098_ VSS VSS VDD VDD _030_ sky130_fd_sc_hd__mux2_2
X_230_ shreg\[1\] net17 _098_ VSS VSS VDD VDD _031_ sky130_fd_sc_hd__mux2_2
X_231_ shreg\[0\] net16 _098_ VSS VSS VDD VDD _032_ sky130_fd_sc_hd__mux2_2
X_232_ state\[1\] _073_ VSS VSS VDD VDD _007_ sky130_fd_sc_hd__or2_2
X_233_ _064_ _097_ VSS VSS VDD VDD _099_ sky130_fd_sc_hd__nand2_1
X_234_ state\[0\] net3 _099_ state\[2\] VSS VSS VDD VDD _008_
+ sky130_fd_sc_hd__a22o_1
X_235_ shreg\[7\] _127_ _133_ shreg\[6\] VSS VSS VDD VDD _100_
+ sky130_fd_sc_hd__o22ai_1
X_236_ shreg\[7\] _130_ _043_ net11 VSS VSS VDD VDD _101_
+ sky130_fd_sc_hd__o22ai_1
X_237_ state\[2\] _100_ _101_ VSS VSS VDD VDD _033_ sky130_fd_sc_hd__a21oi_1
X_238_ net12 VSS VSS VDD VDD _102_ sky130_fd_sc_hd__inv_1
X_239_ _102_ state\[1\] net3 VSS VSS VDD VDD _103_ sky130_fd_sc_hd__mux2i_1
X_240_ state\[0\] _103_ VSS VSS VDD VDD _104_ sky130_fd_sc_hd__nand2_1
X_241_ state\[1\] _102_ _104_ VSS VSS VDD VDD _034_ sky130_fd_sc_hd__o21ai_0
X_242_ bit_cnt\[2\] bit_cnt\[0\] bit_cnt\[1\] VSS VSS VDD
+ VDD _105_ sky130_fd_sc_hd__nand3_1
X_243_ _042_ bit_cnt\[3\] _049_ VSS VSS VDD VDD _106_ sky130_fd_sc_hd__or3_1
X_244_ _071_ _105_ state\[2\] bit_cnt\[3\] VSS VSS VDD VDD
+ _107_ sky130_fd_sc_hd__o211ai_1
X_245_ bit_cnt\[3\] _049_ VSS VSS VDD VDD _108_ sky130_fd_sc_hd__nand2_1
X_246_ _071_ _105_ _106_ _107_ _108_ VSS VSS VDD VDD _035_
+ sky130_fd_sc_hd__o311ai_0
X_247_ state\[2\] state\[1\] VSS VSS VDD VDD _109_ sky130_fd_sc_hd__nor2_1
X_248_ state\[2\] shreg\[7\] net11 _109_ VSS VSS VDD VDD _110_
+ sky130_fd_sc_hd__a22o_1
X_249_ _042_ _073_ _097_ VSS VSS VDD VDD _111_ sky130_fd_sc_hd__nor3_1
X_250_ state\[1\] net3 state\[0\] VSS VSS VDD VDD _112_ sky130_fd_sc_hd__mux2i_1
X_251_ state\[2\] _112_ VSS VSS VDD VDD _113_ sky130_fd_sc_hd__nor2_1
X_252_ _096_ _111_ _113_ VSS VSS VDD VDD _114_ sky130_fd_sc_hd__a21oi_1
X_253_ _110_ net15 _114_ VSS VSS VDD VDD _036_ sky130_fd_sc_hd__mux2_2
X_254_ div_cnt\[7\] VSS VSS VDD VDD _115_ sky130_fd_sc_hd__inv_1
X_255_ div_cnt\[6\] div_cnt\[0\] div_cnt\[1\] _077_ VSS VSS
+ VDD VDD _116_ sky130_fd_sc_hd__nand4_1
X_256_ _076_ _116_ _049_ VSS VSS VDD VDD _117_ sky130_fd_sc_hd__a21oi_1
X_257_ _115_ _076_ VSS VSS VDD VDD _118_ sky130_fd_sc_hd__nand2_1
X_258_ _115_ _117_ _118_ _116_ VSS VSS VDD VDD _037_ sky130_fd_sc_hd__o22ai_1
X_259_ state\[0\] VSS VSS VDD VDD _119_ sky130_fd_sc_hd__inv_1
X_260_ _119_ net13 _007_ VSS VSS VDD VDD _038_ sky130_fd_sc_hd__a21o_1
X_261_ shreg\[7\] net23 _098_ VSS VSS VDD VDD _039_ sky130_fd_sc_hd__mux2_2
X_262_ _131_ _132_ _128_ VSS VSS VDD VDD _120_ sky130_fd_sc_hd__a21oi_1
X_263_ _127_ _120_ state\[2\] VSS VSS VDD VDD _121_ sky130_fd_sc_hd__o21ai_0
X_264_ state\[2\] _128_ state\[0\] _121_ VSS VSS VDD VDD _040_
+ sky130_fd_sc_hd__o31ai_1
X_265_ state\[2\] _064_ _097_ VSS VSS VDD VDD _006_ sky130_fd_sc_hd__and3_1
X_266_ div_cnt\[0\] div_cnt\[1\] VSS VSS VDD VDD _000_ _001_
+ sky130_fd_sc_hd__ha_1
X_267_ div_cnt\[0\] div_cnt\[1\] VSS VSS VDD VDD _002_ _135_
+ sky130_fd_sc_hd__ha_1
X_268_ bit_cnt\[0\] bit_cnt\[1\] VSS VSS VDD VDD _003_ _004_
+ sky130_fd_sc_hd__ha_1
X_269_ bit_cnt\[0\] bit_cnt\[1\] VSS VSS VDD VDD _005_ _136_
+ sky130_fd_sc_hd__ha_1
Xbit_cnt\[0\]$_DFFE_PN0P_ clknet_2_3__leaf_clk _018_ net26
+ VSS VSS VDD VDD bit_cnt\[0\] sky130_fd_sc_hd__dfrtp_1
Xbit_cnt\[1\]$_DFFE_PN0P_ clknet_2_3__leaf_clk _017_ net26
+ VSS VSS VDD VDD bit_cnt\[1\] sky130_fd_sc_hd__dfrtp_1
Xbit_cnt\[2\]$_DFFE_PN0P_ clknet_2_3__leaf_clk _016_ net26
+ VSS VSS VDD VDD bit_cnt\[2\] sky130_fd_sc_hd__dfrtp_1
Xbit_cnt\[3\]$_DFFE_PN0P_ clknet_2_3__leaf_clk _035_ net26
+ VSS VSS VDD VDD bit_cnt\[3\] sky130_fd_sc_hd__dfrtp_1
Xbusy$_DFFE_PN0P_ clknet_2_2__leaf_clk _034_ net26 VSS VSS
+ VDD VDD net12 sky130_fd_sc_hd__dfrtp_1
Xcs_n$_DFFE_PN1P_ clknet_2_3__leaf_clk _038_ net26 VSS VSS
+ VDD VDD net13 sky130_fd_sc_hd__dfstp_2
Xdiv_cnt\[0\]$_DFFE_PN0P_ clknet_2_1__leaf_clk _025_ net26
+ VSS VSS VDD VDD div_cnt\[0\] sky130_fd_sc_hd__dfrtp_1
Xdiv_cnt\[1\]$_DFFE_PN0P_ clknet_2_1__leaf_clk _024_ net26
+ VSS VSS VDD VDD div_cnt\[1\] sky130_fd_sc_hd__dfrtp_1
Xdiv_cnt\[2\]$_DFFE_PN0P_ clknet_2_1__leaf_clk _023_ net26
+ VSS VSS VDD VDD div_cnt\[2\] sky130_fd_sc_hd__dfrtp_1
Xdiv_cnt\[3\]$_DFFE_PN0P_ clknet_2_1__leaf_clk _022_ net26
+ VSS VSS VDD VDD div_cnt\[3\] sky130_fd_sc_hd__dfrtp_1
Xdiv_cnt\[4\]$_DFFE_PN0P_ clknet_2_3__leaf_clk _021_ net26
+ VSS VSS VDD VDD div_cnt\[4\] sky130_fd_sc_hd__dfrtp_1
Xdiv_cnt\[5\]$_DFFE_PN0P_ clknet_2_1__leaf_clk _020_ net26
+ VSS VSS VDD VDD div_cnt\[5\] sky130_fd_sc_hd__dfrtp_1
Xdiv_cnt\[6\]$_DFFE_PN0P_ clknet_2_0__leaf_clk _019_ net26
+ VSS VSS VDD VDD div_cnt\[6\] sky130_fd_sc_hd__dfrtp_1
Xdiv_cnt\[7\]$_DFFE_PN0P_ clknet_2_0__leaf_clk _037_ net26
+ VSS VSS VDD VDD div_cnt\[7\] sky130_fd_sc_hd__dfrtp_1
Xdone$_DFF_PN0_ clknet_2_2__leaf_clk state\[1\] net26 VSS
+ VSS VDD VDD net14 sky130_fd_sc_hd__dfrtp_1
Xmosi$_DFFE_PN0P_ clknet_2_2__leaf_clk _036_ net26 VSS VSS
+ VDD VDD net15 sky130_fd_sc_hd__dfrtp_1
Xrx_data\[0\]$_DFFE_PN0P_ clknet_2_0__leaf_clk _032_ net26
+ VSS VSS VDD VDD net16 sky130_fd_sc_hd__dfrtp_1
Xrx_data\[1\]$_DFFE_PN0P_ clknet_2_0__leaf_clk _031_ net26
+ VSS VSS VDD VDD net17 sky130_fd_sc_hd__dfrtp_1
Xrx_data\[2\]$_DFFE_PN0P_ clknet_2_1__leaf_clk _030_ net26
+ VSS VSS VDD VDD net18 sky130_fd_sc_hd__dfrtp_1
Xrx_data\[3\]$_DFFE_PN0P_ clknet_2_0__leaf_clk _029_ net26
+ VSS VSS VDD VDD net19 sky130_fd_sc_hd__dfrtp_1
Xrx_data\[4\]$_DFFE_PN0P_ clknet_2_0__leaf_clk _028_ net26
+ VSS VSS VDD VDD net20 sky130_fd_sc_hd__dfrtp_1
Xrx_data\[5\]$_DFFE_PN0P_ clknet_2_2__leaf_clk _027_ net26
+ VSS VSS VDD VDD net21 sky130_fd_sc_hd__dfrtp_1
Xrx_data\[6\]$_DFFE_PN0P_ clknet_2_2__leaf_clk _026_ net26
+ VSS VSS VDD VDD net22 sky130_fd_sc_hd__dfrtp_1
Xrx_data\[7\]$_DFFE_PN0P_ clknet_2_2__leaf_clk _039_ net26
+ VSS VSS VDD VDD net23 sky130_fd_sc_hd__dfrtp_1
Xsclk$_DFFE_PN0P_ clknet_2_2__leaf_clk _040_ net26 VSS VSS
+ VDD VDD net24 sky130_fd_sc_hd__dfrtp_1
Xshreg\[0\]$_DFFE_PN0P_ clknet_2_0__leaf_clk _015_ net26 VSS
+ VSS VDD VDD shreg\[0\] sky130_fd_sc_hd__dfrtp_1
Xshreg\[1\]$_DFFE_PN0P_ clknet_2_0__leaf_clk _014_ net26 VSS
+ VSS VDD VDD shreg\[1\] sky130_fd_sc_hd__dfrtp_1
Xshreg\[2\]$_DFFE_PN0P_ clknet_2_0__leaf_clk _013_ net26 VSS
+ VSS VDD VDD shreg\[2\] sky130_fd_sc_hd__dfrtp_1
Xshreg\[3\]$_DFFE_PN0P_ clknet_2_0__leaf_clk _012_ net26 VSS
+ VSS VDD VDD shreg\[3\] sky130_fd_sc_hd__dfrtp_1
Xshreg\[4\]$_DFFE_PN0P_ clknet_2_0__leaf_clk _011_ net26 VSS
+ VSS VDD VDD shreg\[4\] sky130_fd_sc_hd__dfrtp_1
Xshreg\[5\]$_DFFE_PN0P_ clknet_2_2__leaf_clk _010_ net26 VSS
+ VSS VDD VDD shreg\[5\] sky130_fd_sc_hd__dfrtp_1
Xshreg\[6\]$_DFFE_PN0P_ clknet_2_2__leaf_clk _009_ net26 VSS
+ VSS VDD VDD shreg\[6\] sky130_fd_sc_hd__dfrtp_1
Xshreg\[7\]$_DFFE_PN0P_ clknet_2_2__leaf_clk _033_ net26 VSS
+ VSS VDD VDD shreg\[7\] sky130_fd_sc_hd__dfrtp_1
Xstate\[0\]$_DFF_PN1_ clknet_2_3__leaf_clk _007_ net26 VSS
+ VSS VDD VDD state\[0\] sky130_fd_sc_hd__dfstp_2
Xstate\[1\]$_DFF_PN0_ clknet_2_3__leaf_clk _006_ net26 VSS
+ VSS VDD VDD state\[1\] sky130_fd_sc_hd__dfrtp_1
Xstate\[2\]$_DFF_PN0_ clknet_2_3__leaf_clk _008_ net26 VSS
+ VSS VDD VDD state\[2\] sky130_fd_sc_hd__dfrtp_1
XTAP_TAPCELL_ROW_0_0 VSS VDD sky130_fd_sc_hd__tapvpwrvgnd_1
XTAP_TAPCELL_ROW_0_1 VSS VDD sky130_fd_sc_hd__tapvpwrvgnd_1
XTAP_TAPCELL_ROW_0_2 VSS VDD sky130_fd_sc_hd__tapvpwrvgnd_1
XTAP_TAPCELL_ROW_0_3 VSS VDD sky130_fd_sc_hd__tapvpwrvgnd_1
XTAP_TAPCELL_ROW_0_4 VSS VDD sky130_fd_sc_hd__tapvpwrvgnd_1
XTAP_TAPCELL_ROW_1_5 VSS VDD sky130_fd_sc_hd__tapvpwrvgnd_1
XTAP_TAPCELL_ROW_1_6 VSS VDD sky130_fd_sc_hd__tapvpwrvgnd_1
XTAP_TAPCELL_ROW_2_7 VSS VDD sky130_fd_sc_hd__tapvpwrvgnd_1
XTAP_TAPCELL_ROW_2_8 VSS VDD sky130_fd_sc_hd__tapvpwrvgnd_1
XTAP_TAPCELL_ROW_2_9 VSS VDD sky130_fd_sc_hd__tapvpwrvgnd_1
XTAP_TAPCELL_ROW_3_10 VSS VDD sky130_fd_sc_hd__tapvpwrvgnd_1
XTAP_TAPCELL_ROW_3_11 VSS VDD sky130_fd_sc_hd__tapvpwrvgnd_1
XTAP_TAPCELL_ROW_4_12 VSS VDD sky130_fd_sc_hd__tapvpwrvgnd_1
XTAP_TAPCELL_ROW_4_13 VSS VDD sky130_fd_sc_hd__tapvpwrvgnd_1
XTAP_TAPCELL_ROW_4_14 VSS VDD sky130_fd_sc_hd__tapvpwrvgnd_1
XTAP_TAPCELL_ROW_5_15 VSS VDD sky130_fd_sc_hd__tapvpwrvgnd_1
XTAP_TAPCELL_ROW_5_16 VSS VDD sky130_fd_sc_hd__tapvpwrvgnd_1
XTAP_TAPCELL_ROW_6_17 VSS VDD sky130_fd_sc_hd__tapvpwrvgnd_1
XTAP_TAPCELL_ROW_6_18 VSS VDD sky130_fd_sc_hd__tapvpwrvgnd_1
XTAP_TAPCELL_ROW_6_19 VSS VDD sky130_fd_sc_hd__tapvpwrvgnd_1
XTAP_TAPCELL_ROW_7_20 VSS VDD sky130_fd_sc_hd__tapvpwrvgnd_1
XTAP_TAPCELL_ROW_7_21 VSS VDD sky130_fd_sc_hd__tapvpwrvgnd_1
XTAP_TAPCELL_ROW_8_22 VSS VDD sky130_fd_sc_hd__tapvpwrvgnd_1
XTAP_TAPCELL_ROW_8_23 VSS VDD sky130_fd_sc_hd__tapvpwrvgnd_1
XTAP_TAPCELL_ROW_8_24 VSS VDD sky130_fd_sc_hd__tapvpwrvgnd_1
XTAP_TAPCELL_ROW_9_25 VSS VDD sky130_fd_sc_hd__tapvpwrvgnd_1
XTAP_TAPCELL_ROW_9_26 VSS VDD sky130_fd_sc_hd__tapvpwrvgnd_1
XTAP_TAPCELL_ROW_10_27 VSS VDD sky130_fd_sc_hd__tapvpwrvgnd_1
XTAP_TAPCELL_ROW_10_28 VSS VDD sky130_fd_sc_hd__tapvpwrvgnd_1
XTAP_TAPCELL_ROW_10_29 VSS VDD sky130_fd_sc_hd__tapvpwrvgnd_1
XTAP_TAPCELL_ROW_11_30 VSS VDD sky130_fd_sc_hd__tapvpwrvgnd_1
XTAP_TAPCELL_ROW_11_31 VSS VDD sky130_fd_sc_hd__tapvpwrvgnd_1
XTAP_TAPCELL_ROW_12_32 VSS VDD sky130_fd_sc_hd__tapvpwrvgnd_1
XTAP_TAPCELL_ROW_12_33 VSS VDD sky130_fd_sc_hd__tapvpwrvgnd_1
XTAP_TAPCELL_ROW_12_34 VSS VDD sky130_fd_sc_hd__tapvpwrvgnd_1
XTAP_TAPCELL_ROW_13_35 VSS VDD sky130_fd_sc_hd__tapvpwrvgnd_1
XTAP_TAPCELL_ROW_13_36 VSS VDD sky130_fd_sc_hd__tapvpwrvgnd_1
XTAP_TAPCELL_ROW_14_37 VSS VDD sky130_fd_sc_hd__tapvpwrvgnd_1
XTAP_TAPCELL_ROW_14_38 VSS VDD sky130_fd_sc_hd__tapvpwrvgnd_1
XTAP_TAPCELL_ROW_14_39 VSS VDD sky130_fd_sc_hd__tapvpwrvgnd_1
XTAP_TAPCELL_ROW_15_40 VSS VDD sky130_fd_sc_hd__tapvpwrvgnd_1
XTAP_TAPCELL_ROW_15_41 VSS VDD sky130_fd_sc_hd__tapvpwrvgnd_1
XTAP_TAPCELL_ROW_16_42 VSS VDD sky130_fd_sc_hd__tapvpwrvgnd_1
XTAP_TAPCELL_ROW_16_43 VSS VDD sky130_fd_sc_hd__tapvpwrvgnd_1
XTAP_TAPCELL_ROW_16_44 VSS VDD sky130_fd_sc_hd__tapvpwrvgnd_1
XTAP_TAPCELL_ROW_17_45 VSS VDD sky130_fd_sc_hd__tapvpwrvgnd_1
XTAP_TAPCELL_ROW_17_46 VSS VDD sky130_fd_sc_hd__tapvpwrvgnd_1
XTAP_TAPCELL_ROW_18_47 VSS VDD sky130_fd_sc_hd__tapvpwrvgnd_1
XTAP_TAPCELL_ROW_18_48 VSS VDD sky130_fd_sc_hd__tapvpwrvgnd_1
XTAP_TAPCELL_ROW_18_49 VSS VDD sky130_fd_sc_hd__tapvpwrvgnd_1
XTAP_TAPCELL_ROW_19_50 VSS VDD sky130_fd_sc_hd__tapvpwrvgnd_1
XTAP_TAPCELL_ROW_19_51 VSS VDD sky130_fd_sc_hd__tapvpwrvgnd_1
XTAP_TAPCELL_ROW_20_52 VSS VDD sky130_fd_sc_hd__tapvpwrvgnd_1
XTAP_TAPCELL_ROW_20_53 VSS VDD sky130_fd_sc_hd__tapvpwrvgnd_1
XTAP_TAPCELL_ROW_20_54 VSS VDD sky130_fd_sc_hd__tapvpwrvgnd_1
XTAP_TAPCELL_ROW_21_55 VSS VDD sky130_fd_sc_hd__tapvpwrvgnd_1
XTAP_TAPCELL_ROW_21_56 VSS VDD sky130_fd_sc_hd__tapvpwrvgnd_1
XTAP_TAPCELL_ROW_22_57 VSS VDD sky130_fd_sc_hd__tapvpwrvgnd_1
XTAP_TAPCELL_ROW_22_58 VSS VDD sky130_fd_sc_hd__tapvpwrvgnd_1
XTAP_TAPCELL_ROW_22_59 VSS VDD sky130_fd_sc_hd__tapvpwrvgnd_1
XTAP_TAPCELL_ROW_23_60 VSS VDD sky130_fd_sc_hd__tapvpwrvgnd_1
XTAP_TAPCELL_ROW_23_61 VSS VDD sky130_fd_sc_hd__tapvpwrvgnd_1
XTAP_TAPCELL_ROW_24_62 VSS VDD sky130_fd_sc_hd__tapvpwrvgnd_1
XTAP_TAPCELL_ROW_24_63 VSS VDD sky130_fd_sc_hd__tapvpwrvgnd_1
XTAP_TAPCELL_ROW_24_64 VSS VDD sky130_fd_sc_hd__tapvpwrvgnd_1
XTAP_TAPCELL_ROW_25_65 VSS VDD sky130_fd_sc_hd__tapvpwrvgnd_1
XTAP_TAPCELL_ROW_25_66 VSS VDD sky130_fd_sc_hd__tapvpwrvgnd_1
XTAP_TAPCELL_ROW_26_67 VSS VDD sky130_fd_sc_hd__tapvpwrvgnd_1
XTAP_TAPCELL_ROW_26_68 VSS VDD sky130_fd_sc_hd__tapvpwrvgnd_1
XTAP_TAPCELL_ROW_26_69 VSS VDD sky130_fd_sc_hd__tapvpwrvgnd_1
XTAP_TAPCELL_ROW_26_70 VSS VDD sky130_fd_sc_hd__tapvpwrvgnd_1
XTAP_TAPCELL_ROW_26_71 VSS VDD sky130_fd_sc_hd__tapvpwrvgnd_1
Xinput8 tx_data[4] VSS VSS VDD VDD net8 sky130_fd_sc_hd__clkdlybuf4s50_1
Xinput9 tx_data[5] VSS VSS VDD VDD net9 sky130_fd_sc_hd__clkdlybuf4s50_1
Xinput10 tx_data[6] VSS VSS VDD VDD net10 sky130_fd_sc_hd__clkdlybuf4s50_1
Xinput11 tx_data[7] VSS VSS VDD VDD net11 sky130_fd_sc_hd__clkdlybuf4s50_1
Xoutput12 net12 VSS VSS VDD VDD busy sky130_fd_sc_hd__clkdlybuf4s50_1
Xoutput13 net13 VSS VSS VDD VDD cs_n sky130_fd_sc_hd__clkdlybuf4s50_1
Xoutput14 net14 VSS VSS VDD VDD done sky130_fd_sc_hd__clkdlybuf4s50_1
Xoutput15 net15 VSS VSS VDD VDD mosi sky130_fd_sc_hd__clkdlybuf4s50_1
Xoutput16 net16 VSS VSS VDD VDD rx_data[0] sky130_fd_sc_hd__clkdlybuf4s50_1
Xoutput17 net17 VSS VSS VDD VDD rx_data[1] sky130_fd_sc_hd__clkdlybuf4s50_1
Xoutput18 net18 VSS VSS VDD VDD rx_data[2] sky130_fd_sc_hd__clkdlybuf4s50_1
Xoutput19 net19 VSS VSS VDD VDD rx_data[3] sky130_fd_sc_hd__clkdlybuf4s50_1
Xoutput20 net20 VSS VSS VDD VDD rx_data[4] sky130_fd_sc_hd__clkdlybuf4s50_1
Xoutput21 net21 VSS VSS VDD VDD rx_data[5] sky130_fd_sc_hd__clkdlybuf4s50_1
Xoutput22 net22 VSS VSS VDD VDD rx_data[6] sky130_fd_sc_hd__clkdlybuf4s50_1
Xoutput23 net23 VSS VSS VDD VDD rx_data[7] sky130_fd_sc_hd__clkdlybuf4s50_1
Xoutput24 net24 VSS VSS VDD VDD sclk sky130_fd_sc_hd__clkdlybuf4s50_1
Xclkbuf_0_clk clk VSS VSS VDD VDD clknet_0_clk sky130_fd_sc_hd__clkbuf_8
Xplace26 net2 VSS VSS VDD VDD net26 sky130_fd_sc_hd__buf_4
Xclkbuf_2_0__f_clk clknet_0_clk VSS VSS VDD VDD clknet_2_0__leaf_clk
+ sky130_fd_sc_hd__clkbuf_8
Xclkbuf_2_1__f_clk clknet_0_clk VSS VSS VDD VDD clknet_2_1__leaf_clk
+ sky130_fd_sc_hd__clkbuf_8
Xclkbuf_2_2__f_clk clknet_0_clk VSS VSS VDD VDD clknet_2_2__leaf_clk
+ sky130_fd_sc_hd__clkbuf_8
Xclkbuf_2_3__f_clk clknet_0_clk VSS VSS VDD VDD clknet_2_3__leaf_clk
+ sky130_fd_sc_hd__clkbuf_8
Xclkload0 clknet_2_1__leaf_clk VSS VSS VDD VDD _unconnected_0
+ sky130_fd_sc_hd__clkinvlp_4
Xclkload1 clknet_2_2__leaf_clk VSS VSS VDD VDD _unconnected_1
+ sky130_fd_sc_hd__clkbuf_1
Xclkload2 clknet_2_3__leaf_clk VSS VSS VDD VDD _unconnected_2
+ sky130_fd_sc_hd__clkbuf_8
.ENDS spi_master
